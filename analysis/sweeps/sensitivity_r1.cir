* SiC JFET inverter: single-axis sensitivity sweep (r1)
* Generated by tools/gen_sensitivity_testbench.py from cpus/4004/config.py.
* Do not edit by hand -- re-run the generator after tuning the CPU.

.model DR NJF (Beta=0.000135 Betatce=-0.5 Vto=-3.45 Vtotc=-0.0025 Lambda=0.005 Is=2.052e-13 Xti=3 Isr=1.988e-12 Nr=4 Alpha=2.098e-05 Vk=123.7 N=3 Rd=1 Rs=1 Cgs=1.69e-11 Cgd=1.69e-11)

* Supplies (use .param so V can be swept on this axis if applicable)
.param vpos=24
.param vneg=-20
VPOS VPOS 0 {vpos}
VNEG VNEG 0 {vneg}

* Hand-tuned R values (the swept one is overridden by .step below)
.param r1=50000

.subckt INV2J vin vout VPOS VNEG
R1 VPOS A {r1}
J1 A 0 vin DR
J2 VPOS B A DR
R2 B vout 1k
R3 vout VNEG 4.5k
.ends INV2J

* Test instance
X1 in out VPOS VNEG INV2J

* Slow clock -- 10000 Hz, square wave between rails
V_IN in 0 PULSE(-3.6 -0.8 100n 100n 100n 5e-05 0.0001)

* Sweep
.step param r1 list 40000 45000 50000 55000 60000

* Two full periods; settle measurements come from the second.
.tran 0 0.0002 0.0001 1e-07

* Measurements (one row per step in the .log).
.meas tran v_oh MAX V(out) FROM=0.00015 TO=0.0002
.meas tran v_ol MIN V(out) FROM=0.0001 TO=0.00015
.meas tran swing PARAM v_oh-v_ol
.meas tran t_pd_rise TRIG V(in)  VAL=-2.2 RISE=1 TARG V(out) VAL=-2.2 FALL=1
.meas tran t_pd_fall TRIG V(in)  VAL=-2.2 FALL=1 TARG V(out) VAL=-2.2 RISE=1

.end
