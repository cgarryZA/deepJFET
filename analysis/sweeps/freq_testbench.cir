* SiC JFET RTL inverter chain (N=4): frequency sweep test bench
* Generated by tools/gen_freq_testbench.py from cpus/4004/config.py.
* Do not edit by hand -- re-run the generator after tuning the CPU.

* --- device model ---
.model DR NJF (Beta=0.000135 Betatce=-0.5 Vto=-3.45 Vtotc=-0.0025 Lambda=0.005 Is=2.052e-13 Xti=3 Isr=1.988e-12 Nr=4 Alpha=2.098e-05 Vk=123.7 N=3 Rd=1 Rs=1 Cgs=1.69e-11 Cgd=1.69e-11)

* --- supplies (fixed at config.py nominal) ---
VPOS VPOS 0 24
VNEG VNEG 0 -20

* --- 2-JFET inverter subcircuit with hand-tuned R values ---
.subckt INV2J vin vout VPOS VNEG
R1 VPOS A 50k
J1 A 0 vin DR
J2 VPOS B A DR
R2 B vout 1k
R3 vout VNEG 4.5k
.ends INV2J

* --- swept clock frequency ---
.param freq=100k
V_IN in 0 PULSE(-3.6 -0.8 100n 100n 100n {0.5/freq} {1/freq})

* --- N-inverter chain under test ---
X1 in n1 VPOS VNEG INV2J
X2 n1 n2 VPOS VNEG INV2J
X3 n2 n3 VPOS VNEG INV2J
X4 n3 out VPOS VNEG INV2J

* --- sweep ---
.step dec param freq 10k 2Meg 10

* --- transient ---
* Run 20 clock periods, log the final settled period only.
.tran 0 {20/freq} {18/freq} {0.01/freq}

* --- measurements (one row per step in the .log) ---
.meas tran v_oh MAX V(out) FROM={18.5/freq} TO={20/freq}
.meas tran v_ol MIN V(out) FROM={18.5/freq} TO={20/freq}
.meas tran swing PARAM v_oh-v_ol
* Propagation delay across the 4-gate chain, mid-rail threshold.
* (For an even chain length, in and out are in phase; threshold = -2.2 V.)
.meas tran t_pd_rise TRIG V(in)  VAL=-2.2 RISE=1 TARG V(out) VAL=-2.2 RISE=1
.meas tran t_pd_fall TRIG V(in)  VAL=-2.2 FALL=1 TARG V(out) VAL=-2.2 FALL=1

.end
